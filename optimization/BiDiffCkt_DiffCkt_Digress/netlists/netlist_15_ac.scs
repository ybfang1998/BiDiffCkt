simulator lang = spectre
global 0

// include the pdk path
// sample pdk import
// include "/data/tools/PDKs/TSMC/europractice/extracted/65/CMOS/LP/pdk/cadence_oa/tsmcN65/../models/spectre/toplevel.scs" section=tt_lib

parameters VDD_VAL=1.2
V1 (Vdd 0) vsource dc=VDD_VAL
Vinp (VIN 0) vsource dc=VDD_VAL/2

V_DM_pos (VINP VIN) vsource dc=0 mag=1
V_DM_neg (VINN Vout) vsource dc=0 mag=1

// CMOS pins sequence: (D G S B)

IBIASP_I_ref (IBIASP 0) isource dc=1uA
IBIASP_M_bias (IBIASP IBIASP Vdd Vdd) pch w=1u l=1u

subckt current_mirror_nmos_1 In Out Sources VSS
    parameters W=1u L=1u
    M1 (In In Sources VSS) nch w=W l=L
    M2 (Out In Sources VSS) nch w=W l=L
ends current_mirror_nmos_1

subckt diff_pair_pmos_1 InP InN OutP OutN Sources VDD
    parameters W=1u L=1u
    M1 (OutP InP Sources VDD) pch w=W l=L
    M2 (OutN InN Sources VDD) pch w=W l=L
ends diff_pair_pmos_1

subckt current_mirror_nmos_2 In Out Sources VSS
    parameters W=1u L=1u
    M1 (In In Sources VSS) nch w=W l=L
    M2 (Out In Sources VSS) nch w=W l=L
ends current_mirror_nmos_2

I0 (net1 IBIASP Vdd Vdd) pch w=1 l=1
I1 (net4 net2 0 0) current_mirror_nmos_1 W=1 L=1
I2 (net2 net5) capacitor c=1
I3 (VINN VINP net4 net2 net6 Vdd) diff_pair_pmos_1 W=1 L=1
I4 (net5 Vout) resistor r=1
I5 (Vout net1 0 0) nch w=1 l=1
I6 (net3 net1 0 0) current_mirror_nmos_2 W=1 L=1
I7 (Vout IBIASP Vdd Vdd) pch w=1 l=1
I8 (net1 net5) capacitor c=1
I9 (net6 IBIASP Vdd Vdd) pch w=1 l=1
I10 (net3 net2 Vdd Vdd) pch w=1 l=1

// Load and IProbe
C_Load (Vout 0) capacitor c=1e-12

//Simulation Setting
ac ac start=1 stop=1e11 annotate=status

simulator lang=spectre
global 0

subckt tc_stage_1 GND IN OUT
    G0 (OUT GND IN GND) vccs gm=0.7686494792763573m
    R0 (OUT GND) resistor r=0.07155407176204633M
    C0 (IN GND) capacitor c=0.6119820694875456p
ends tc_stage_1
subckt tc_stage_neg_1 GND IN OUT
    G0 (OUT GND IN GND) vccs gm=-0.2741997356322733m
    R0 (OUT GND) resistor r=0.17870184990153837M
    C0 (IN GND) capacitor c=0.21831189142696916p
ends tc_stage_neg_1
subckt tc_stage_2 GND IN OUT
    G0 (OUT GND IN GND) vccs gm=0.6687849851962353m
    R0 (OUT GND) resistor r=0.10765791935187317M
    C0 (IN GND) capacitor c=0.5324721219715249p
ends tc_stage_2
subckt r_c_s_1 IN OUT
    R0 (IN net1) resistor r=0.4874332633667256M
  C0 (net1 OUT) capacitor c=8.660521615535401p
ends r_c_s_1

I0 (0 net2 net1) tc_stage_1
I1 (0 VIN net2) tc_stage_neg_1
I2 (0 net1 OUT) tc_stage_2
I3 (VIN OUT) r_c_s_1
V0 (VIN 0) vsource dc=0 mag=1m type=sine ampl=1m freq=1K

C_L (OUT 0) capacitor c=10p
R_L (OUT 0) resistor r=10M

ac ac start=1 stop=1e9 dec=100 annotate=status

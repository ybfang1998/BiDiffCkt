simulator lang=spectre
global 0

subckt ts_r_c_s_1 GND IN OUT
    C1 (net1 OUT) capacitor c=9.546481445222938p
    R1 (IN net1) resistor r=0.27384312257142185M
    G0 (OUT GND IN GND) vccs gm=0.6145734580264741m
    R0 (OUT GND) resistor r=0.10739155610777598M
    C0 (IN GND) capacitor c=0.48931007804655585p
ends ts_r_c_s_1
subckt tc_stage_neg_1 GND IN OUT
    G0 (OUT GND IN GND) vccs gm=-0.492987924143509m
    R0 (OUT GND) resistor r=0.11156459886021361M
    C0 (IN GND) capacitor c=0.3925063090314562p
ends tc_stage_neg_1
subckt tc_stage_neg_2 GND IN OUT
    G0 (OUT GND IN GND) vccs gm=-0.7357515742330207m
    R0 (OUT GND) resistor r=0.05572533098925432M
    C0 (IN GND) capacitor c=0.585789469930749p
ends tc_stage_neg_2
subckt tc_stage_neg_3 GND IN OUT
    G0 (OUT GND IN GND) vccs gm=-0.11480715258663136m
    R0 (OUT GND) resistor r=0.6619796614383568M
    C0 (IN GND) capacitor c=0.09140696861992942p
ends tc_stage_neg_3
subckt tc_stage_neg_4 GND IN OUT
    G0 (OUT GND IN GND) vccs gm=-0.49354776944507994m
    R0 (OUT GND) resistor r=0.11954263326189601M
    C0 (IN GND) capacitor c=0.39295204573652864p
ends tc_stage_neg_4

I0 (0 VIN OUT) ts_r_c_s_1
I1 (0 net1 net2) tc_stage_neg_1
I2 (0 VIN net1) tc_stage_neg_2
I3 (0 VIN net2) tc_stage_neg_3
I4 (0 net2 OUT) tc_stage_neg_4
V0 (VIN 0) vsource dc=0 mag=1m type=sine ampl=1m freq=1K

C_L (OUT 0) capacitor c=10p
R_L (OUT 0) resistor r=10M

ac ac start=1 stop=1e9 dec=100 annotate=status

simulator lang=spectre
global 0

subckt tc_stage_neg_1 GND IN OUT
    G0 (OUT GND IN GND) vccs gm=-0.6326406978186248m
    R0 (OUT GND) resistor r=0.08377583070887872M
    C0 (IN GND) capacitor c=0.5036948231040006p
ends tc_stage_neg_1
subckt tc_stage_neg_2 GND IN OUT
    G0 (OUT GND IN GND) vccs gm=-0.6882023851083988m
    R0 (OUT GND) resistor r=0.061028559198301205M
    C0 (IN GND) capacitor c=0.5479318352773875p
ends tc_stage_neg_2
subckt ts_c_p_neg_1 GND IN OUT
    C1 (IN OUT) capacitor c=9.20936971030818p
    G0 (OUT GND IN GND) vccs gm=-0.34027363625922896m
    R0 (OUT GND) resistor r=0.16751224287201605M
    C0 (IN GND) capacitor c=0.27091850020639247p
ends ts_c_p_neg_1
subckt single_r_1 IN OUT
    R0 (IN OUT) resistor r=0.20280605322603404M
ends single_r_1
subckt ts_r_c_p_neg_1 GND IN OUT
    C1 (IN OUT) capacitor c=1.6164342364017446p
    R1 (IN OUT) resistor r=0.4385068144911619M
    G0 (OUT GND IN GND) vccs gm=-0.7488987075216805m
    R0 (OUT GND) resistor r=0.06943529141889274M
    C0 (IN GND) capacitor c=0.5962569327401914p
ends ts_r_c_p_neg_1

I0 (0 VIN net1) tc_stage_neg_1
I1 (0 net2 OUT) tc_stage_neg_2
I2 (0 net1 net2) ts_c_p_neg_1
I3 (VIN net2) single_r_1
I4 (0 OUT net2) ts_r_c_p_neg_1
V0 (VIN 0) vsource dc=0 mag=1m type=sine ampl=1m freq=1K

C_L (OUT 0) capacitor c=10p
R_L (OUT 0) resistor r=10M

ac ac start=1 stop=1e9 dec=100 annotate=status

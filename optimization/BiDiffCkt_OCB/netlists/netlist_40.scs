simulator lang=spectre
global 0

subckt ts_r_p_1 GND IN OUT
    R1 (IN OUT) resistor r=0.4440607591792145M
    G0 (OUT GND IN GND) vccs gm=0.7598495782847886m
    R0 (OUT GND) resistor r=0.08422719684133727M
    C0 (IN GND) capacitor c=0.6049757788891629p
ends ts_r_p_1
subckt tc_stage_neg_1 GND IN OUT
    G0 (OUT GND IN GND) vccs gm=-0.18755874692524915m
    R0 (OUT GND) resistor r=0.30923644431851366M
    C0 (IN GND) capacitor c=0.1493302125201028p
ends tc_stage_neg_1
subckt r_c_p_1 IN OUT
    R0 (IN OUT) resistor r=0.04739965016417865M
  C0 (IN OUT) capacitor c=0.27224921345391406p
ends r_c_p_1
subckt tc_stage_1 GND IN OUT
    G0 (OUT GND IN GND) vccs gm=0.06346048465848907m
    R0 (OUT GND) resistor r=1.0715329447283648M
    C0 (IN GND) capacitor c=0.05052586358159957p
ends tc_stage_1
subckt tc_stage_neg_2 GND IN OUT
    G0 (OUT GND IN GND) vccs gm=-0.6046734883713396m
    R0 (OUT GND) resistor r=0.08268925455070424M
    C0 (IN GND) capacitor c=0.48142793660138505p
ends tc_stage_neg_2

I0 (0 OUT net1) ts_r_p_1
I1 (0 net2 OUT) tc_stage_neg_1
I2 (VIN OUT) r_c_p_1
I3 (0 VIN net1) tc_stage_1
I4 (0 net1 net2) tc_stage_neg_2
V0 (VIN 0) vsource dc=0 mag=1m type=sine ampl=1m freq=1K

C_L (OUT 0) capacitor c=10p
R_L (OUT 0) resistor r=10M

ac ac start=1 stop=1e9 dec=100 annotate=status

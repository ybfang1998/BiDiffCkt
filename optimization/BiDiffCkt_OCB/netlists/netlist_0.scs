simulator lang=spectre
global 0

subckt tc_stage_1 GND IN OUT
    G0 (OUT GND IN GND) vccs gm=0.02359296166913387m
    R0 (OUT GND) resistor r=2.9246010300720795M
    C0 (IN GND) capacitor c=0.01878420515058429p
ends tc_stage_1
subckt r_c_p_1 IN OUT
    R0 (IN OUT) resistor r=0.6686718457090565M
  C0 (IN OUT) capacitor c=1.2685950434947049p
ends r_c_p_1
subckt single_r_1 IN OUT
    R0 (IN OUT) resistor r=0.4365706352237577M
ends single_r_1
subckt ts_r_c_s_neg_1 GND IN OUT
    C1 (net1 OUT) capacitor c=9.693654560825715p
    R1 (IN net1) resistor r=0.07913477613198136M
    G0 (OUT GND IN GND) vccs gm=-0.02084034339300882m
    R0 (OUT GND) resistor r=3.742740631911381M
    C0 (IN GND) capacitor c=0.016592630089975177p
ends ts_r_c_s_neg_1
subckt ts_c_p_1 GND IN OUT
    C1 (IN OUT) capacitor c=4.6106071326596245p
    G0 (OUT GND IN GND) vccs gm=0.05463199125233006m
    R0 (OUT GND) resistor r=1.0250404335685201M
    C0 (IN GND) capacitor c=0.04349680832191883p
ends ts_c_p_1
subckt ts_c_p_2 GND IN OUT
    C1 (IN OUT) capacitor c=3.9765281949547293p
    G0 (OUT GND IN GND) vccs gm=0.6611175429826475m
    R0 (OUT GND) resistor r=0.10134355185573796M
    C0 (IN GND) capacitor c=0.5263674705275855p
ends ts_c_p_2

I0 (0 VIN net1) tc_stage_1
I1 (net1 net2) r_c_p_1
I2 (net2 OUT) single_r_1
I3 (0 OUT net2) ts_r_c_s_neg_1
I4 (0 net1 net2) ts_c_p_1
I5 (0 net2 OUT) ts_c_p_2
V0 (VIN 0) vsource dc=0 mag=1m type=sine ampl=1m freq=1K

C_L (OUT 0) capacitor c=10p
R_L (OUT 0) resistor r=10M

ac ac start=1 stop=1e9 dec=100 annotate=status

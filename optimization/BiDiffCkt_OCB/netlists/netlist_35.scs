simulator lang=spectre
global 0

subckt ts_r_p_neg_1 GND IN OUT
    R1 (IN OUT) resistor r=0.8837979207322919M
    G0 (OUT GND IN GND) vccs gm=-0.4113005278203861m
    R0 (OUT GND) resistor r=0.11427167441060222M
    C0 (IN GND) capacitor c=0.3274685731054029p
ends ts_r_p_neg_1
subckt r_c_s_1 IN OUT
    R0 (IN net1) resistor r=0.5460938259969124M
  C0 (net1 OUT) capacitor c=2.6070879261401987p
ends r_c_s_1
subckt ts_c_p_neg_1 GND IN OUT
    C1 (IN OUT) capacitor c=4.856899175759263p
    G0 (OUT GND IN GND) vccs gm=-0.7723762095442821m
    R0 (OUT GND) resistor r=0.05178823416065705M
    C0 (IN GND) capacitor c=0.6149492114206068p
ends ts_c_p_neg_1
subckt ts_c_p_1 GND IN OUT
    C1 (IN OUT) capacitor c=7.3402146795907015p
    G0 (OUT GND IN GND) vccs gm=0.15440629257513935m
    R0 (OUT GND) resistor r=0.49220791933085123M
    C0 (IN GND) capacitor c=0.1229349463177861p
ends ts_c_p_1
subckt tc_stage_neg_1 GND IN OUT
    G0 (OUT GND IN GND) vccs gm=-0.20399356991431375m
    R0 (OUT GND) resistor r=0.19608461196498378M
    C0 (IN GND) capacitor c=0.16241526267063197p
ends tc_stage_neg_1
subckt ts_r_p_neg_2 GND IN OUT
    R1 (IN OUT) resistor r=0.04813892018807898M
    G0 (OUT GND IN GND) vccs gm=-0.09714192627854522m
    R0 (OUT GND) resistor r=0.6691240588910982M
    C0 (IN GND) capacitor c=0.0773422979924723p
ends ts_r_p_neg_2

I0 (0 VIN net2) ts_r_p_neg_1
I1 (VIN OUT) r_c_s_1
I2 (0 VIN net1) ts_c_p_neg_1
I3 (0 net1 net2) ts_c_p_1
I4 (0 net2 OUT) tc_stage_neg_1
I5 (0 VIN net1) ts_r_p_neg_2
V0 (VIN 0) vsource dc=0 mag=1m type=sine ampl=1m freq=1K

C_L (OUT 0) capacitor c=10p
R_L (OUT 0) resistor r=10M

ac ac start=1 stop=1e9 dec=100 annotate=status

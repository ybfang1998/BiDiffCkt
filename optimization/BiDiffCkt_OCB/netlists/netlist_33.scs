simulator lang=spectre
global 0

subckt ts_c_p_1 GND IN OUT
    C1 (IN OUT) capacitor c=0.9408364487060972p
    G0 (OUT GND IN GND) vccs gm=0.11005164612783043m
    R0 (OUT GND) resistor r=0.5088519978606519M
    C0 (IN GND) capacitor c=0.08762073736292231p
ends ts_c_p_1
subckt single_c_1 IN OUT
    C0 (IN OUT) capacitor c=9.119942126354733p
ends single_c_1
subckt ts_c_p_2 GND IN OUT
    C1 (IN OUT) capacitor c=5.502161603383485p
    G0 (OUT GND IN GND) vccs gm=0.08865122541640705m
    R0 (OUT GND) resistor r=0.7557707147903681M
    C0 (IN GND) capacitor c=0.07058218584108841p
ends ts_c_p_2
subckt single_r_1 IN OUT
    R0 (IN OUT) resistor r=0.9858667310360177M
ends single_r_1
subckt tc_stage_neg_1 GND IN OUT
    G0 (OUT GND IN GND) vccs gm=-0.7584356621986185m
    R0 (OUT GND) resistor r=0.08438421765990184M
    C0 (IN GND) capacitor c=0.603850049521193p
ends tc_stage_neg_1

I0 (0 net2 net1) ts_c_p_1
I1 (net2 net1) single_c_1
I2 (0 VIN net2) ts_c_p_2
I3 (VIN OUT) single_r_1
I4 (0 net1 OUT) tc_stage_neg_1
V0 (VIN 0) vsource dc=0 mag=1m type=sine ampl=1m freq=1K

C_L (OUT 0) capacitor c=10p
R_L (OUT 0) resistor r=10M

ac ac start=1 stop=1e9 dec=100 annotate=status

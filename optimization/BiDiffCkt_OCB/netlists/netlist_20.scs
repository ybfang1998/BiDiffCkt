simulator lang=spectre
global 0

subckt ts_r_c_p_neg_1 GND IN OUT
    C1 (IN OUT) capacitor c=9.08960691024173p
    R1 (IN OUT) resistor r=0.8023424200112036M
    G0 (OUT GND IN GND) vccs gm=-0.3557239369419613m
    R0 (OUT GND) resistor r=0.1658589537358748M
    C0 (IN GND) capacitor c=0.2832196950174851p
ends ts_r_c_p_neg_1
subckt ts_r_c_p_neg_2 GND IN OUT
    C1 (IN OUT) capacitor c=5.890115870128905p
    R1 (IN OUT) resistor r=0.11895394374566962M
    G0 (OUT GND IN GND) vccs gm=-0.48489069872813123m
    R0 (OUT GND) resistor r=0.14023779003879447M
    C0 (IN GND) capacitor c=0.38605947350965863p
ends ts_r_c_p_neg_2
subckt ts_c_p_1 GND IN OUT
    C1 (IN OUT) capacitor c=7.903828895276472p
    G0 (OUT GND IN GND) vccs gm=0.7348169479937455m
    R0 (OUT GND) resistor r=0.08981828764319923M
    C0 (IN GND) capacitor c=0.5850453407593516p
ends ts_c_p_1
subckt tc_stage_1 GND IN OUT
    G0 (OUT GND IN GND) vccs gm=0.9386670856572369m
    R0 (OUT GND) resistor r=0.052201681244305194M
    C0 (IN GND) capacitor c=0.7473464057780548p
ends tc_stage_1
subckt tc_stage_neg_1 GND IN OUT
    G0 (OUT GND IN GND) vccs gm=-0.06849441561316423m
    R0 (OUT GND) resistor r=0.9489824742370293M
    C0 (IN GND) capacitor c=0.054533770392646674p
ends tc_stage_neg_1

I0 (0 OUT net2) ts_r_c_p_neg_1
I1 (0 VIN net2) ts_r_c_p_neg_2
I2 (0 VIN net1) ts_c_p_1
I3 (0 net2 OUT) tc_stage_1
I4 (0 net1 net2) tc_stage_neg_1
V0 (VIN 0) vsource dc=0 mag=1m type=sine ampl=1m freq=1K

C_L (OUT 0) capacitor c=10p
R_L (OUT 0) resistor r=10M

ac ac start=1 stop=1e9 dec=100 annotate=status
